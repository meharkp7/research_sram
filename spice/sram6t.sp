* 6T SRAM

.model MyNMOS NMOS (LEVEL=1 VTO=0.6 KP=250u LAMBDA=0.02)
.model MyPMOS PMOS (LEVEL=1 VTO=-0.6 KP=120u LAMBDA=0.02)

VDD VDD 0 DC 1.8
AX1 BL WL Q 0 MyNMOS L=1.8e-07 W=1e-06
AX2 BLB WL QB 0 MyNMOS L=1.8e-07 W=1e-06
M1 Q QB VDD VDD MyPMOS L=1.8e-07 W=2e-06
M2 Q QB 0 0 MyNMOS L=1.8e-07 W=1e-06
M1 QB Q VDD VDD MyPMOS L=1.8e-07 W=2e-06
M2 QB Q 0 0 MyNMOS L=1.8e-07 W=1e-06

.end
